* Ideal behavioral buffer model for ASAP7 BUFx4
* Pin order matches CDL: A VDD VSS Y
.SUBCKT BUFx4_ASAP7_75t_R A VDD VSS Y
Ebuf Y VSS A VSS 1.0
.ENDS
